* summer 7-tone (24k off), A=0.424 V peak, A3 for single-tone THD -100 dBc
.param A=0.424
.param A3=2.22e-4
B1 s 0 V=A*(sin(2*pi*20k*time)+sin(2*pi*22k*time)+sin(2*pi*26k*time)+sin(2*pi*28k*time)+sin(2*pi*30k*time)+sin(2*pi*32k*time)+sin(2*pi*34k*time))
B2 out 0 V=V(s)+A3*V(s)*V(s)*V(s)
.tran 0 10m 0 100n
.end
