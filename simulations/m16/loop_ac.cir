* M16 current-loop AC only
Vcmd cmd 0 DC 0 AC 0
Vinj inj 0 DC 0 AC 1
Eea ea 0 LAPLACE {V(cmd)-V(sense)}={1e6*(1+s/(2*pi*30k))/((1+s/(2*pi*10))*(1+s/(2*pi*3meg)))}
Ebuf buf 0 ea inj 1
C1 buf coil 100u
L1 coil sense 70u
R1 coil sense 2
Rsen sense 0 1
.ac dec 300 100 3meg
.end
