* summer 7-tone (24k off), gain 1.5: per-tone 0.316 V peak, same A3 as the 2.0103 case
.param A=0.316
.param A3=2.22e-4
B1 s 0 V=A*(sin(2*pi*20k*time)+sin(2*pi*22k*time)+sin(2*pi*26k*time)+sin(2*pi*28k*time)+sin(2*pi*30k*time)+sin(2*pi*32k*time)+sin(2*pi*34k*time))
B2 out 0 V=V(s)+A3*V(s)*V(s)*V(s)
.tran 0 10m 0 100n
.end
